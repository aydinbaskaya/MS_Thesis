# Ansys Electronics Desktop project, version 2017.0
materials:
  vacuum: permittivity=1
  steel_1008: permeability{BType=normal HUnit=A_per_meter BUnit=tesla curve (0, 0) (159.2, 0.2402) (318.3, 0.8654) (477.5, 1.1106) (636.6, 1.2458) (795.8, 1.331) (1591.5, 1.5) (3183.1, 1.6) (4774.6, 1.683) (6366.2, 1.741) (7957.7, 1.78) (15915.5, 1.905) (31831, 2.025) (47746.5, 2.085) (63662, 2.13) (79577.5, 2.165) (159155, 2.28) (318310, 2.485) (397887, 2.5851)} conductivity=2000000
  Arnold_Magnetics_N50H_100C: permeability{BType=normal HUnit=A_per_meter BUnit=tesla curve (-660000, -0.8589) (-659000, -0.2881) (-654000, 0.1518) (-645000, 0.3202) (-637000, 0.3687) (-629000, 0.399) (-622000, 0.4215) (-614000, 0.4401) (-606000, 0.4563) (-598000, 0.471) (-590000, 0.4847) (-583000, 0.4977) (-575000, 0.5102) (-567000, 0.5223) (-559000, 0.5341) (-552000, 0.5457) (-544000, 0.557) (-536000, 0.5683) (-528000, 0.5793) (-521000, 0.5903) (-513000, 0.6012) (-505000, 0.612) (-497000, 0.6228) (-489000, 0.6334) (-482000, 0.6441) (-474000, 0.6547) (-466000, 0.6652) (-458000, 0.6757) (-451000, 0.6862) (-443000, 0.6967) (-435000, 0.7071) (-427000, 0.7175) (-420000, 0.7279) (-412000, 0.7383) (-404000, 0.7487) (-396000, 0.759) (-388000, 0.7693) (-381000, 0.7797) (-373000, 0.79) (-365000, 0.8003) (-357000, 0.8106) (-350000, 0.8208) (-342000, 0.8311) (-334000, 0.8414) (-326000, 0.8516) (-319000, 0.8619) (-311000, 0.8721) (-303000, 0.8823) (-295000, 0.8926) (-287000, 0.9028) (-280000, 0.913) (-272000, 0.9232) (-264000, 0.9335) (-256000, 0.9437) (-249000, 0.9539) (-241000, 0.9641) (-233000, 0.9743) (-225000, 0.9845) (-218000, 0.9946) (-210000, 1.0048) (-202000, 1.015) (-194000, 1.0252) (-186000, 1.0354) (-179000, 1.0456) (-171000, 1.0557) (-163000, 1.0659) (-155000, 1.0761) (-148000, 1.0862) (-140000, 1.0964) (-132000, 1.1066) (-124000, 1.1167) (-117000, 1.1269) (-109000, 1.1371) (-101000, 1.1472) (-93000, 1.1574) (-85000, 1.1675) (-78000, 1.1777) (-70000, 1.1878) (-62000, 1.198) (-54000, 1.2081) (-47000, 1.2183) (-39000, 1.2284) (-31000, 1.2386) (-23000, 1.2487) (-16000, 1.2589) (-8000, 1.269) (0, 1.2792)} conductivity=555555.5556 magnetic_coercivity{Magnitude=-1089500A_per_meter DirComp1=1 DirComp2=0 DirComp3=0}
  copper: permeability=0.999991 conductivity=58000000
  Arnold_Magnetics_N50_20C: permeability{BType=normal HUnit=A_per_meter BUnit=tesla curve (-1003000, -1.3041) (-998000, -0.346) (-993000, -0.1488) (-979000, 0.0176) (-967000, 0.0757) (-956000, 0.1136) (-944000, 0.1428) (-932000, 0.1675) (-920000, 0.1896) (-908000, 0.2101) (-897000, 0.2295) (-885000, 0.2481) (-873000, 0.2661) (-861000, 0.2836) (-849000, 0.3009) (-838000, 0.3178) (-826000, 0.3346) (-814000, 0.3511) (-802000, 0.3676) (-790000, 0.3839) (-779000, 0.4001) (-767000, 0.4162) (-755000, 0.4323) (-743000, 0.4483) (-731000, 0.4642) (-720000, 0.4801) (-708000, 0.4959) (-696000, 0.5117) (-684000, 0.5275) (-672000, 0.5432) (-661000, 0.559) (-649000, 0.5746) (-637000, 0.5903) (-625000, 0.606) (-613000, 0.6216) (-602000, 0.6372) (-590000, 0.6528) (-578000, 0.6684) (-566000, 0.6839) (-554000, 0.6995) (-543000, 0.715) (-531000, 0.7306) (-519000, 0.7461) (-507000, 0.7616) (-495000, 0.7771) (-484000, 0.7926) (-472000, 0.8081) (-460000, 0.8236) (-448000, 0.8391) (-436000, 0.8546) (-425000, 0.87) (-413000, 0.8855) (-401000, 0.901) (-389000, 0.9164) (-377000, 0.9319) (-366000, 0.9473) (-354000, 0.9628) (-342000, 0.9782) (-330000, 0.9937) (-319000, 1.0091) (-307000, 1.0245) (-295000, 1.0399) (-283000, 1.0554) (-271000, 1.0708) (-260000, 1.0862) (-248000, 1.1016) (-236000, 1.117) (-224000, 1.1325) (-212000, 1.1479) (-201000, 1.1633) (-189000, 1.1787) (-177000, 1.1941) (-165000, 1.2095) (-153000, 1.2249) (-142000, 1.2403) (-130000, 1.2557) (-118000, 1.2711) (-106000, 1.2865) (-94000, 1.3019) (-83000, 1.3173) (-71000, 1.3327) (-59000, 1.3481) (-47000, 1.3635) (-35000, 1.3788) (-24000, 1.3942) (-12000, 1.4096) (0, 1.425)} conductivity=555555.5556 magnetic_coercivity{Magnitude=-880000A_per_meter DirComp1=0 DirComp2=-1 DirComp3=0}
  Arnold_Magnetics_N50_20C_N: permeability{BType=normal HUnit=A_per_meter BUnit=tesla curve (-1003000, -1.3041) (-998000, -0.346) (-993000, -0.1488) (-979000, 0.0176) (-967000, 0.0757) (-956000, 0.1136) (-944000, 0.1428) (-932000, 0.1675) (-920000, 0.1896) (-908000, 0.2101) (-897000, 0.2295) (-885000, 0.2481) (-873000, 0.2661) (-861000, 0.2836) (-849000, 0.3009) (-838000, 0.3178) (-826000, 0.3346) (-814000, 0.3511) (-802000, 0.3676) (-790000, 0.3839) (-779000, 0.4001) (-767000, 0.4162) (-755000, 0.4323) (-743000, 0.4483) (-731000, 0.4642) (-720000, 0.4801) (-708000, 0.4959) (-696000, 0.5117) (-684000, 0.5275) (-672000, 0.5432) (-661000, 0.559) (-649000, 0.5746) (-637000, 0.5903) (-625000, 0.606) (-613000, 0.6216) (-602000, 0.6372) (-590000, 0.6528) (-578000, 0.6684) (-566000, 0.6839) (-554000, 0.6995) (-543000, 0.715) (-531000, 0.7306) (-519000, 0.7461) (-507000, 0.7616) (-495000, 0.7771) (-484000, 0.7926) (-472000, 0.8081) (-460000, 0.8236) (-448000, 0.8391) (-436000, 0.8546) (-425000, 0.87) (-413000, 0.8855) (-401000, 0.901) (-389000, 0.9164) (-377000, 0.9319) (-366000, 0.9473) (-354000, 0.9628) (-342000, 0.9782) (-330000, 0.9937) (-319000, 1.0091) (-307000, 1.0245) (-295000, 1.0399) (-283000, 1.0554) (-271000, 1.0708) (-260000, 1.0862) (-248000, 1.1016) (-236000, 1.117) (-224000, 1.1325) (-212000, 1.1479) (-201000, 1.1633) (-189000, 1.1787) (-177000, 1.1941) (-165000, 1.2095) (-153000, 1.2249) (-142000, 1.2403) (-130000, 1.2557) (-118000, 1.2711) (-106000, 1.2865) (-94000, 1.3019) (-83000, 1.3173) (-71000, 1.3327) (-59000, 1.3481) (-47000, 1.3635) (-35000, 1.3788) (-24000, 1.3942) (-12000, 1.4096) (0, 1.425)} conductivity=555555.5556 magnetic_coercivity{Magnitude=-880000A_per_meter DirComp1=0 DirComp2=1 DirComp3=0}
  Arnold_Magnetics_N50_20C_S: permeability{BType=normal HUnit=A_per_meter BUnit=tesla curve (-1003000, -1.3041) (-998000, -0.346) (-993000, -0.1488) (-979000, 0.0176) (-967000, 0.0757) (-956000, 0.1136) (-944000, 0.1428) (-932000, 0.1675) (-920000, 0.1896) (-908000, 0.2101) (-897000, 0.2295) (-885000, 0.2481) (-873000, 0.2661) (-861000, 0.2836) (-849000, 0.3009) (-838000, 0.3178) (-826000, 0.3346) (-814000, 0.3511) (-802000, 0.3676) (-790000, 0.3839) (-779000, 0.4001) (-767000, 0.4162) (-755000, 0.4323) (-743000, 0.4483) (-731000, 0.4642) (-720000, 0.4801) (-708000, 0.4959) (-696000, 0.5117) (-684000, 0.5275) (-672000, 0.5432) (-661000, 0.559) (-649000, 0.5746) (-637000, 0.5903) (-625000, 0.606) (-613000, 0.6216) (-602000, 0.6372) (-590000, 0.6528) (-578000, 0.6684) (-566000, 0.6839) (-554000, 0.6995) (-543000, 0.715) (-531000, 0.7306) (-519000, 0.7461) (-507000, 0.7616) (-495000, 0.7771) (-484000, 0.7926) (-472000, 0.8081) (-460000, 0.8236) (-448000, 0.8391) (-436000, 0.8546) (-425000, 0.87) (-413000, 0.8855) (-401000, 0.901) (-389000, 0.9164) (-377000, 0.9319) (-366000, 0.9473) (-354000, 0.9628) (-342000, 0.9782) (-330000, 0.9937) (-319000, 1.0091) (-307000, 1.0245) (-295000, 1.0399) (-283000, 1.0554) (-271000, 1.0708) (-260000, 1.0862) (-248000, 1.1016) (-236000, 1.117) (-224000, 1.1325) (-212000, 1.1479) (-201000, 1.1633) (-189000, 1.1787) (-177000, 1.1941) (-165000, 1.2095) (-153000, 1.2249) (-142000, 1.2403) (-130000, 1.2557) (-118000, 1.2711) (-106000, 1.2865) (-94000, 1.3019) (-83000, 1.3173) (-71000, 1.3327) (-59000, 1.3481) (-47000, 1.3635) (-35000, 1.3788) (-24000, 1.3942) (-12000, 1.4096) (0, 1.425)} conductivity=555555.5556 magnetic_coercivity{Magnitude=-880000A_per_meter DirComp1=0 DirComp2=-1 DirComp3=0}

design design_magnetostatic (Maxwell 3D, Magnetostatic, model units mm)
variables:
  r_o = 4.701meter
  r_web = 4.335meter
  Np = 216
  lc = 0.0215meter
  l_ss = 0.0889meter
  t_o = 0.03meter
  t_i = 0.02meter
  r_i = 4.44meter
  width_ratio = 0.737
  hm = 0.0171meter
  coil_ratio = 0.382
  tau_c = 0.177meter
  tw = coil_ratio*tau_c
  hw = 0.0406meter
  g = 0.007meter
  theta_ins = 0.01deg
geometry:
  Steel_pole_3 [steel_1008] = circle(normal=Y, centre=(0mm, 0mm, 0mm), radius=r_o)
  Circle2 = circle(normal=Y, centre=(0mm, 0mm, 0mm), radius=r_web)
  Steel_pole_3.subtract(Circle2)
  Steel_pole_3.split(plane=XY, keep=PositiveOnly)
  Steel_pole_3.split(plane=YZ, keep=PositiveOnly)
  Steel_pole_3.rotate(axis=Y, angle=-2*pi/Np)
  Steel_pole_3.split(plane=YZ, keep=NegativeOnly)
  Steel_pole_3.sweep_along_vector((0meter, (0.867/1.25) meter, 0meter))
  Circle3 = circle(normal=Y, centre=(0mm, 0mm, 0mm), radius=r_o)
  Circle4 = circle(normal=Y, centre=(0mm, 0mm, 0mm), radius=r_web+lc)
  Circle3.subtract(Circle4)
  Circle3.split(plane=XY, keep=PositiveOnly)
  Circle3.split(plane=YZ, keep=PositiveOnly)
  Circle3.rotate(axis=Y, angle=-2*pi/Np)
  Circle3.split(plane=YZ, keep=NegativeOnly)
  Circle3.sweep_along_vector((0mm, l_ss, 0mm))
  Circle3.move(0mm, t_o, 0mm)
  Circle3_1..Circle3_5 = Circle3.duplicate_along_line(step=(0mm, t_i+l_ss, 0mm), total=6)
  Steel_pole_3.subtract(Circle3, Circle3_1..Circle3_5)
  PM_N [Arnold_Magnetics_N50_20C_N] = circle(normal=Y, centre=(0mm, 0mm, 0mm), radius=r_o)
  Circle6 = circle(normal=Y, centre=(0mm, 0mm, 0mm), radius=r_i)
  PM_N.subtract(Circle6)
  PM_N.split(plane=XY, keep=PositiveOnly)
  PM_N.split(plane=YZ, keep=NegativeOnly)
  PM_N.rotate(axis=Y, angle=(2*pi/Np)*width_ratio)
  PM_N.split(plane=YZ, keep=PositiveOnly)
  PM_N.rotate(axis=Y, angle=-2*pi/Np+(2*pi/Np)*(1-width_ratio)/2)
  PM_N.move(0mm, 30mm, 0mm)
  PM_N.sweep_along_vector((0mm, hm, 0mm))
  PM_N_1..PM_N_5 [Arnold_Magnetics_N50_20C_N] = PM_N.duplicate_along_line(step=(0mm, t_i+l_ss, 0mm), total=6)
  PM_N_6 [Arnold_Magnetics_N50_20C_N] = PM_N.duplicate_along_line(step=(0mm, l_ss-hm, 0mm), total=2)
  PM_N_7..PM_N_11 [Arnold_Magnetics_N50_20C_N] = PM_N_6.duplicate_along_line(step=(0mm, l_ss+t_i, 0mm), total=6)
  Coil [copper] = circle(normal=Y, centre=(0mm, 0mm, 0mm), radius=tw+r_o)
  Circle8 = circle(normal=Y, centre=(0mm, 0mm, 0mm), radius=r_i-tw)
  Coil.subtract(Circle8)
  Coil.split(plane=XY, keep=PositiveOnly)
  Coil.split(plane=YZ, keep=NegativeOnly)
  Coil.rotate(axis=Y, angle=(2*pi/Np)*(4/3))
  Coil.split(plane=YZ, keep=PositiveOnly)
  Coil.rotate(axis=Y, angle=-(2*pi/Np))
  Circle9 = circle(normal=Y, centre=(0mm, 0mm, 0mm), radius=r_o)
  Circle10 = circle(normal=Y, centre=(0mm, 0mm, 0mm), radius=r_i)
  Circle9.subtract(Circle10)
  Circle9.split(plane=XY, keep=PositiveOnly)
  Circle9.split(plane=YZ, keep=NegativeOnly)
  Circle9.rotate(axis=Y, angle=(2*pi/Np)*(4/3)*(1-2*coil_ratio))
  Circle9.split(plane=YZ, keep=PositiveOnly)
  Circle9.rotate(axis=Y, angle=-(2*pi/Np))
  Circle9.rotate(axis=Y, angle=(2*pi/Np)*(4/3)*(coil_ratio))
  Coil.subtract(Circle9)
  Coil.rotate(axis=Y, angle=-(2*pi/Np)*(4/3))
  Coil.rotate(axis=Y, angle=(2*pi/Np)+theta_ins)
  Coil.split(plane=YZ, keep=NegativeOnly)
  Coil.rotate(axis=Y, angle=-theta_ins)
  Coil.rotate(axis=Y, angle=(2*pi/Np)*4/3-theta_ins)
  Coil.split(plane=YZ, keep=PositiveOnly)
  Coil.rotate(axis=Y, angle=-(2*pi/Np)*4/3+theta_ins)
  Coil.sweep_along_vector((0mm, hw, 0mm))
  Coil.move(0mm, t_o+hm+g, 0mm)
  Steel_pole, Steel_pole_1, Steel_pole_2 [steel_1008] = Steel_pole_3.duplicate_around_axis(axis=Y, angle=-(2*pi/Np), total=4)
  PM_S [Arnold_Magnetics_N50_20C_S], PM_N_12 [Arnold_Magnetics_N50_20C_N], PM_S_12 [Arnold_Magnetics_N50_20C_S] = PM_N.duplicate_around_axis(axis=Y, angle=-(2*pi/Np), total=4)
  PM_S_1 [Arnold_Magnetics_N50_20C_S], PM_N_13 [Arnold_Magnetics_N50_20C_N], PM_S_13 [Arnold_Magnetics_N50_20C_S] = PM_N_1.duplicate_around_axis(axis=Y, angle=-(2*pi/Np), total=4)
  PM_S_2 [Arnold_Magnetics_N50_20C_S], PM_N_14 [Arnold_Magnetics_N50_20C_N], PM_S_14 [Arnold_Magnetics_N50_20C_S] = PM_N_2.duplicate_around_axis(axis=Y, angle=-(2*pi/Np), total=4)
  PM_S_3 [Arnold_Magnetics_N50_20C_S], PM_N_15 [Arnold_Magnetics_N50_20C_N], PM_S_15 [Arnold_Magnetics_N50_20C_S] = PM_N_3.duplicate_around_axis(axis=Y, angle=-(2*pi/Np), total=4)
  PM_S_4 [Arnold_Magnetics_N50_20C_S], PM_N_16 [Arnold_Magnetics_N50_20C_N], PM_S_16 [Arnold_Magnetics_N50_20C_S] = PM_N_4.duplicate_around_axis(axis=Y, angle=-(2*pi/Np), total=4)
  PM_S_5 [Arnold_Magnetics_N50_20C_S], PM_N_17 [Arnold_Magnetics_N50_20C_N], PM_S_17 [Arnold_Magnetics_N50_20C_S] = PM_N_5.duplicate_around_axis(axis=Y, angle=-(2*pi/Np), total=4)
  PM_S_6 [Arnold_Magnetics_N50_20C_S], PM_N_18 [Arnold_Magnetics_N50_20C_N], PM_S_18 [Arnold_Magnetics_N50_20C_S] = PM_N_6.duplicate_around_axis(axis=Y, angle=-(2*pi/Np), total=4)
  PM_S_7 [Arnold_Magnetics_N50_20C_S], PM_N_19 [Arnold_Magnetics_N50_20C_N], PM_S_19 [Arnold_Magnetics_N50_20C_S] = PM_N_7.duplicate_around_axis(axis=Y, angle=-(2*pi/Np), total=4)
  PM_S_8 [Arnold_Magnetics_N50_20C_S], PM_N_20 [Arnold_Magnetics_N50_20C_N], PM_S_20 [Arnold_Magnetics_N50_20C_S] = PM_N_8.duplicate_around_axis(axis=Y, angle=-(2*pi/Np), total=4)
  PM_S_9 [Arnold_Magnetics_N50_20C_S], PM_N_21 [Arnold_Magnetics_N50_20C_N], PM_S_21 [Arnold_Magnetics_N50_20C_S] = PM_N_9.duplicate_around_axis(axis=Y, angle=-(2*pi/Np), total=4)
  PM_S_10 [Arnold_Magnetics_N50_20C_S], PM_N_22 [Arnold_Magnetics_N50_20C_N], PM_S_22 [Arnold_Magnetics_N50_20C_S] = PM_N_10.duplicate_around_axis(axis=Y, angle=-(2*pi/Np), total=4)
  PM_S_11 [Arnold_Magnetics_N50_20C_S], PM_N_23 [Arnold_Magnetics_N50_20C_N], PM_S_23 [Arnold_Magnetics_N50_20C_S] = PM_N_11.duplicate_around_axis(axis=Y, angle=-(2*pi/Np), total=4)
  Coil_1, Coil_2 [copper] = Coil.duplicate_around_axis(axis=Y, angle=-(2*pi/Np)*4/3, total=3)
  Coil_3..Coil_7 [copper] = Coil.duplicate_along_line(step=(0mm, 2*g+2*hm+t_i+hw, 0mm), total=6)
  Coil_8..Coil_12 [copper] = Coil_1.duplicate_along_line(step=(0mm, 2*g+2*hm+t_i+hw, 0mm), total=6)
  Coil_13..Coil_17 [copper] = Coil_2.duplicate_along_line(step=(0mm, 2*g+2*hm+t_i+hw, 0mm), total=6)
  Region [vacuum] = circle(normal=Y, centre=(0mm, 0mm, 0mm), radius=4900mm)
  Region.split(plane=XY, keep=PositiveOnly)
  Region.split(plane=YZ, keep=NegativeOnly)
  Region.rotate(axis=Y, angle=(2*pi/Np)*4)
  Region.split(plane=YZ, keep=PositiveOnly)
  Region.rotate(axis=Y, angle=-(2*pi/Np)*4)
  Region.sweep_along_vector((0mm, 693.6mm, 0mm))
  Polyline1 = polyline(xyz in mm: (0, 0, 4571) (-552.49823, -7.1703975e-13, 4537.4868) (-1096.895, -6.884924e-13, 4437.4387), AngularArc from point 0 over 3 centre=(0mm, 0mm, 0mm) angle=13.884668deg plane=ZX)
  Polyline1.rotate(axis=Y, angle=(2*pi/Np)*4)
  Polyline1.split(plane=YZ, keep=PositiveOnly)
  Polyline1.rotate(axis=Y, angle=-(2*pi/Np)*4)
  Polyline1.move(0mm, t_o+hm+g+0.5*hw, 0mm)
boundaries and excitations:
  Master1: Master Faces=Region.face(#6164) CoordSysVector{Region.vertex(#6150) -> Region.vertex(#6159)} ReverseV
  Slave1: Slave Faces=Region.face(#6162) CoordSysVector{Region.vertex(#6150) -> Region.vertex(#6149)} master=Master1 RelationIsSame=true
setups:
  Setup1: Magnetostatic MaximumPasses=10 MinimumPasses=2 MinimumConvergedPasses=1 PercentRefinement=30 PercentError=1 NonLinearResidual=0.001
field calculator expressions:
  By = B_Vector | ScalarY
field plots:
  B_Vector1: B in PM_N, PM_N_1..PM_N_23, PM_S, PM_S_1..PM_S_23, Steel_pole, Steel_pole_1, Steel_pole_2, Steel_pole_3 on Setup1 : LastAdaptive
reports:
  XY Plot 1: By vs Distance on Setup1 : LastAdaptive

design design_transient (Maxwell 3D, Transient, model units mm)
options: Multiplier=1
variables:
  r_o = 4.701meter
  r_web = 4.335meter
  Np = 216
  lc = 0.0215meter
  l_ss = 0.0889meter
  t_o = 0.03meter
  t_i = 0.02meter
  r_i = 4.44meter
  width_ratio = 0.737
  hm = 0.0171meter
  coil_ratio = 0.382
  tau_c = 0.177meter
  tw = coil_ratio*tau_c
  hw = 0.0406meter
  g = 0.007meter
  theta_ins = 0.01deg
  axial_length_total = 693.6mm
geometry:
  Steel_pole_3 [steel_1008] = circle(normal=Y, centre=(0mm, 0mm, 0mm), radius=r_o)
  Circle2 = circle(normal=Y, centre=(0mm, 0mm, 0mm), radius=r_web)
  Steel_pole_3.subtract(Circle2)
  Steel_pole_3.split(plane=XY, keep=PositiveOnly)
  Steel_pole_3.split(plane=YZ, keep=PositiveOnly)
  Steel_pole_3.rotate(axis=Y, angle=-2*pi/Np)
  Steel_pole_3.split(plane=YZ, keep=NegativeOnly)
  Steel_pole_3.sweep_along_vector((0meter, (0.867/1.25) meter, 0meter))
  Circle3 = circle(normal=Y, centre=(0mm, 0mm, 0mm), radius=r_o)
  Circle4 = circle(normal=Y, centre=(0mm, 0mm, 0mm), radius=r_web+lc)
  Circle3.subtract(Circle4)
  Circle3.split(plane=XY, keep=PositiveOnly)
  Circle3.split(plane=YZ, keep=PositiveOnly)
  Circle3.rotate(axis=Y, angle=-2*pi/Np)
  Circle3.split(plane=YZ, keep=NegativeOnly)
  Circle3.sweep_along_vector((0mm, l_ss, 0mm))
  Circle3.move(0mm, t_o, 0mm)
  Circle3_1..Circle3_5 = Circle3.duplicate_along_line(step=(0mm, t_i+l_ss, 0mm), total=6)
  Steel_pole_3.subtract(Circle3, Circle3_1..Circle3_5)
  PM_N [Arnold_Magnetics_N50_20C_N] = circle(normal=Y, centre=(0mm, 0mm, 0mm), radius=r_o)
  Circle6 = circle(normal=Y, centre=(0mm, 0mm, 0mm), radius=r_i)
  PM_N.subtract(Circle6)
  PM_N.split(plane=XY, keep=PositiveOnly)
  PM_N.split(plane=YZ, keep=NegativeOnly)
  PM_N.rotate(axis=Y, angle=(2*pi/Np)*width_ratio)
  PM_N.split(plane=YZ, keep=PositiveOnly)
  PM_N.rotate(axis=Y, angle=-2*pi/Np+(2*pi/Np)*(1-width_ratio)/2)
  PM_N.move(0mm, 30mm, 0mm)
  PM_N.sweep_along_vector((0mm, hm, 0mm))
  PM_N_1..PM_N_5 [Arnold_Magnetics_N50_20C_N] = PM_N.duplicate_along_line(step=(0mm, t_i+l_ss, 0mm), total=6)
  PM_N_6 [Arnold_Magnetics_N50_20C_N] = PM_N.duplicate_along_line(step=(0mm, l_ss-hm, 0mm), total=2)
  PM_N_7..PM_N_11 [Arnold_Magnetics_N50_20C_N] = PM_N_6.duplicate_along_line(step=(0mm, l_ss+t_i, 0mm), total=6)
  Coil [copper] = circle(normal=Y, centre=(0mm, 0mm, 0mm), radius=tw+r_o)
  Circle8 = circle(normal=Y, centre=(0mm, 0mm, 0mm), radius=r_i-tw)
  Coil.subtract(Circle8)
  Coil.split(plane=XY, keep=PositiveOnly)
  Coil.split(plane=YZ, keep=NegativeOnly)
  Coil.rotate(axis=Y, angle=(2*pi/Np)*(4/3))
  Coil.split(plane=YZ, keep=PositiveOnly)
  Coil.rotate(axis=Y, angle=-(2*pi/Np))
  Circle9 = circle(normal=Y, centre=(0mm, 0mm, 0mm), radius=r_o)
  Circle10 = circle(normal=Y, centre=(0mm, 0mm, 0mm), radius=r_i)
  Circle9.subtract(Circle10)
  Circle9.split(plane=XY, keep=PositiveOnly)
  Circle9.split(plane=YZ, keep=NegativeOnly)
  Circle9.rotate(axis=Y, angle=(2*pi/Np)*(4/3)*(1-2*coil_ratio))
  Circle9.split(plane=YZ, keep=PositiveOnly)
  Circle9.rotate(axis=Y, angle=-(2*pi/Np))
  Circle9.rotate(axis=Y, angle=(2*pi/Np)*(4/3)*(coil_ratio))
  Coil.subtract(Circle9)
  Coil.rotate(axis=Y, angle=-(2*pi/Np)*(4/3))
  Coil.rotate(axis=Y, angle=(2*pi/Np)+theta_ins)
  Coil.split(plane=YZ, keep=NegativeOnly)
  Coil.rotate(axis=Y, angle=-theta_ins)
  Coil.rotate(axis=Y, angle=(2*pi/Np)*4/3-theta_ins)
  Coil.split(plane=YZ, keep=PositiveOnly)
  Coil.rotate(axis=Y, angle=-(2*pi/Np)*4/3+theta_ins)
  Coil.sweep_along_vector((0mm, hw, 0mm))
  Coil.move(0mm, t_o+hm+g, 0mm)
  Steel_pole, Steel_pole_1, Steel_pole_2 [steel_1008] = Steel_pole_3.duplicate_around_axis(axis=Y, angle=-(2*pi/Np), total=4)
  PM_S [Arnold_Magnetics_N50_20C_S], PM_N_12 [Arnold_Magnetics_N50_20C_N], PM_S_12 [Arnold_Magnetics_N50_20C_S] = PM_N.duplicate_around_axis(axis=Y, angle=-(2*pi/Np), total=4)
  PM_S_1 [Arnold_Magnetics_N50_20C_S], PM_N_13 [Arnold_Magnetics_N50_20C_N], PM_S_13 [Arnold_Magnetics_N50_20C_S] = PM_N_1.duplicate_around_axis(axis=Y, angle=-(2*pi/Np), total=4)
  PM_S_2 [Arnold_Magnetics_N50_20C_S], PM_N_14 [Arnold_Magnetics_N50_20C_N], PM_S_14 [Arnold_Magnetics_N50_20C_S] = PM_N_2.duplicate_around_axis(axis=Y, angle=-(2*pi/Np), total=4)
  PM_S_3 [Arnold_Magnetics_N50_20C_S], PM_N_15 [Arnold_Magnetics_N50_20C_N], PM_S_15 [Arnold_Magnetics_N50_20C_S] = PM_N_3.duplicate_around_axis(axis=Y, angle=-(2*pi/Np), total=4)
  PM_S_4 [Arnold_Magnetics_N50_20C_S], PM_N_16 [Arnold_Magnetics_N50_20C_N], PM_S_16 [Arnold_Magnetics_N50_20C_S] = PM_N_4.duplicate_around_axis(axis=Y, angle=-(2*pi/Np), total=4)
  PM_S_5 [Arnold_Magnetics_N50_20C_S], PM_N_17 [Arnold_Magnetics_N50_20C_N], PM_S_17 [Arnold_Magnetics_N50_20C_S] = PM_N_5.duplicate_around_axis(axis=Y, angle=-(2*pi/Np), total=4)
  PM_S_6 [Arnold_Magnetics_N50_20C_S], PM_N_18 [Arnold_Magnetics_N50_20C_N], PM_S_18 [Arnold_Magnetics_N50_20C_S] = PM_N_6.duplicate_around_axis(axis=Y, angle=-(2*pi/Np), total=4)
  PM_S_7 [Arnold_Magnetics_N50_20C_S], PM_N_19 [Arnold_Magnetics_N50_20C_N], PM_S_19 [Arnold_Magnetics_N50_20C_S] = PM_N_7.duplicate_around_axis(axis=Y, angle=-(2*pi/Np), total=4)
  PM_S_8 [Arnold_Magnetics_N50_20C_S], PM_N_20 [Arnold_Magnetics_N50_20C_N], PM_S_20 [Arnold_Magnetics_N50_20C_S] = PM_N_8.duplicate_around_axis(axis=Y, angle=-(2*pi/Np), total=4)
  PM_S_9 [Arnold_Magnetics_N50_20C_S], PM_N_21 [Arnold_Magnetics_N50_20C_N], PM_S_21 [Arnold_Magnetics_N50_20C_S] = PM_N_9.duplicate_around_axis(axis=Y, angle=-(2*pi/Np), total=4)
  PM_S_10 [Arnold_Magnetics_N50_20C_S], PM_N_22 [Arnold_Magnetics_N50_20C_N], PM_S_22 [Arnold_Magnetics_N50_20C_S] = PM_N_10.duplicate_around_axis(axis=Y, angle=-(2*pi/Np), total=4)
  PM_S_11 [Arnold_Magnetics_N50_20C_S], PM_N_23 [Arnold_Magnetics_N50_20C_N], PM_S_23 [Arnold_Magnetics_N50_20C_S] = PM_N_11.duplicate_around_axis(axis=Y, angle=-(2*pi/Np), total=4)
  Coil_1, Coil_2 [copper] = Coil.duplicate_around_axis(axis=Y, angle=-(2*pi/Np)*4/3, total=3)
  Coil_3..Coil_7 [copper] = Coil.duplicate_along_line(step=(0mm, 2*g+2*hm+t_i+hw, 0mm), total=6)
  Coil_8..Coil_12 [copper] = Coil_1.duplicate_along_line(step=(0mm, 2*g+2*hm+t_i+hw, 0mm), total=6)
  Coil_13..Coil_17 [copper] = Coil_2.duplicate_along_line(step=(0mm, 2*g+2*hm+t_i+hw, 0mm), total=6)
  Region [vacuum] = circle(normal=Y, centre=(0mm, 0mm, 0mm), radius=4900mm)
  Region.split(plane=XY, keep=PositiveOnly)
  Region.split(plane=YZ, keep=NegativeOnly)
  Region.rotate(axis=Y, angle=(2*pi/Np)*4)
  Region.split(plane=YZ, keep=PositiveOnly)
  Region.rotate(axis=Y, angle=-(2*pi/Np)*4)
  Region.sweep_along_vector((0mm, axial_length_total, 0mm))
  Polyline1 = polyline(xyz in mm: (0, 0, 4571) (-552.49823, -7.1703975e-13, 4537.4868) (-1096.895, -6.884924e-13, 4437.4387), AngularArc from point 0 over 3 centre=(0mm, 0mm, 0mm) angle=13.884668deg plane=ZX)
  Polyline1.rotate(axis=Y, angle=(2*pi/Np)*4)
  Polyline1.split(plane=YZ, keep=PositiveOnly)
  Polyline1.rotate(axis=Y, angle=-(2*pi/Np)*4)
  Polyline1.move(0mm, t_o+hm+g+0.5*hw, 0mm)
  inner_region [vacuum] = circle(normal=Y, centre=(0mm, 0mm, 0mm), radius=r_o)
  inner_region.split(plane=XY, keep=PositiveOnly)
  inner_region.split(plane=YZ, keep=NegativeOnly)
  inner_region.rotate(axis=Y, angle=(2*pi/Np)*4)
  inner_region.split(plane=YZ, keep=PositiveOnly)
  inner_region.rotate(axis=Y, angle=-(2*pi/Np)*4)
  inner_region.sweep_along_vector((0mm, axial_length_total, 0mm))
  Circle12 = circle(normal=Y, centre=(0mm, 0mm, 0mm), radius=r_o+tw)
  Circle13 = circle(normal=Y, centre=(0mm, 0mm, 0mm), radius=r_web+lc)
  Circle12.subtract(Circle13)
  Circle12.split(plane=XY, keep=PositiveOnly)
  Circle12.split(plane=YZ, keep=NegativeOnly)
  Circle12.rotate(axis=Y, angle=(2*pi/Np)*4)
  Circle12.split(plane=YZ, keep=PositiveOnly)
  Circle12.rotate(axis=Y, angle=-(2*pi/Np)*4)
  Circle12.move(0mm, t_o+hm+g-0.002, 0mm)
  Circle12.sweep_along_vector((0mm, 0.002+hw+0.002, 0mm))
  Circle12_1..Circle12_5 = Circle12.duplicate_along_line(step=(0mm, g-0.002+2*hm+t_i+g+0.002 +hw, 0mm), total=6)
  inner_region.subtract(Circle12, Circle12_1..Circle12_5)
boundaries and excitations:
  Master1: Master Faces=Region.face(#6164) CoordSysVector{Region.vertex(#6150) -> Region.vertex(#6159)} ReverseV
  Slave1: Slave Faces=Region.face(#6162) CoordSysVector{Region.vertex(#6150) -> Region.vertex(#6149)} master=Master1 RelationIsSame=true
