# Ansys Electronics Desktop project, version 2017.0
materials:
  vacuum: permittivity=1
  copper: permeability=0.999991 conductivity=58000000
  arm_steel: permeability{BType=normal HUnit=A_per_meter BUnit=tesla curve (0, 0) (4000, 1.413) (8010, 1.594) (16010, 1.751) (24020, 1.839) (32030, 1.896) (40030, 1.936) (48040, 1.967) (64050, 2.008) (80070, 2.042) (96080, 2.073) (112100, 2.101) (128110, 2.127) (144120, 2.151) (176150, 2.197) (208180, 2.24) (272230, 2.325) (304260, 2.37) (336290, 2.42) (396000, 2.5)} conductivity=2000000

design parametric_sample (Maxwell 3D, Magnetostatic, model units mm)
variables:
  angle = 29deg
geometry:
  outer_arm [arm_steel] = cylinder(axis=Z, base_centre=(0mm, 0mm, 0mm), radius=104.5mm, height=25.4mm)
  cylinder_tool = cylinder(axis=Z, base_centre=(0mm, 0mm, 0mm), radius=83.1mm, height=25.4mm)
  outer_arm.subtract(cylinder_tool)
  Box1 = box(corner=(-13.9mm, 0mm, 0mm), size=(27.8mm, -40mm, 25.4mm))
  Box1.move(0mm, -45mm, 0mm)
  Box1_1 = Box1.duplicate_mirror(point=(0mm, 0mm, 0mm), normal=(0mm, 1mm, 0mm))
  outer_arm.unite(Box1_1, Box1)
  Cylinder1 = cylinder(axis=Z, base_centre=(0mm, 0mm, 0mm), radius=53.75mm, height=25.4mm)
  inner_arm [arm_steel] = cylinder(axis=Z, base_centre=(0mm, 0mm, 0mm), radius=38.1mm, height=25.4mm)
  outer_arm.subtract(Cylinder1)
  shaft = cylinder(axis=Z, base_centre=(0mm, 0mm, 0mm), radius=25.4mm, height=25.4mm)
  inner_arm.subtract(shaft)
  Box2 = box(corner=(-12.7mm, 0mm, 0mm), size=(25.4mm, -20mm, 25.4mm))
  Box2.move(0mm, -35mm, 0mm)
  Box2_1 = Box2.duplicate_mirror(point=(0mm, 0mm, 0mm), normal=(0mm, 1mm, 0mm))
  inner_arm.unite(Box2, Box2_1)
  final_pole = cylinder(axis=Z, base_centre=(0mm, 0mm, 0mm), radius=51.05mm, height=25.4mm)
  inner_arm.intersect(final_pole)
  coordinate_system RelativeCS1 = origin=(0mm, 0mm, 12.7mm) x=(1mm, 0mm, 0mm) y=(0mm, 1mm, 0mm)
  path = rectangle(corner=(-17mm, 0mm, -15.5mm), z_size=31mm, x_size=34mm) in RelativeCS1
  path.uncover_faces(FacesToUncover=path.face(#344))
  coil1 [copper] = rectangle(corner=(0mm, 0mm, 15.5mm), y_size=17mm, z_size=24mm)
  coil1.sweep_along_path(path)
  round = cylinder(axis=Y, base_centre=(0mm, 0mm, 0mm), radius=43mm, height=17mm) in RelativeCS1
  coil1.intersect(round)
  coil1.move(0mm, 54.5mm, 0mm) in RelativeCS1
  coil1_1 [copper] = coil1.duplicate_mirror(point=(0mm, 0mm, 0mm), normal=(0mm, 1mm, 0mm)) in RelativeCS1
  bgnd [vacuum] = box(corner=(-250mm, -250mm, -250mm), size=(500mm, 500mm, 500mm)) in RelativeCS1
  inner_arm.rotate(axis=Z, angle=angle) in RelativeCS1
  outer_arm_1 = outer_arm.copy()
  coil1.subtract(outer_arm_1)
  outer_arm_2 = outer_arm.copy()
  coil1_1.subtract(outer_arm_2)
  coil1_1_Section1 = coil1_1.section(plane=XY) in RelativeCS1
  coil1_Section1 = coil1.section(plane=XY) in RelativeCS1
  coil1_1_Section1_Separate1 [copper] = coil1_1_Section1.separate_bodies()
  coil1_1_Section1.delete()
  coil1_Section1_Separate1 [copper] = coil1_Section1.separate_bodies()
  coil1_Section1.delete()
  list Objectlist1 = inner_arm, outer_arm
boundaries and excitations:
  Current_1: Current Objects=coil1_1_Section1_Separate1 Current=675.5A IsSolid=false Point_out_of_terminal=false
  Current_2: Current Objects=coil1_Section1_Separate1 Current=675.5A IsSolid=false Point_out_of_terminal=false
parameters:
  Torque1: Torque Is_Virtual=true Coordinate_System=Global Axis=Z Is_Positive=true Objects=inner_arm
setups:
  Setup1: Magnetostatic MaximumPasses=10 MinimumPasses=2 MinimumConvergedPasses=1 PercentRefinement=30 PercentError=1 NonLinearResidual=0.001
optimetrics:
  ParametricSetup1: Parametric Sim._Setups=[Setup1]
    sweep angle: LIN 0deg 30deg 5deg
field plots:
  B_Vector1, Mag_B1: B over a plane on Setup1 : LastAdaptive
reports:
  XY Plot 1: Torque1.Torque vs angle on Setup1 : LastAdaptive
